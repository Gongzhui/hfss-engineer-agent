# Ansys Electronics Desktop project, version 2023.2
materials:
  Rogers RT/duroid 5880 (tm): permittivity=2.2 dielectric_loss_tangent=0.0009
  copper: permeability=0.999991 conductivity=58000000
  vacuum: permittivity=1

design SIW Feed Structure (HFSS, HFSS Hybrid Modal Network, model units mm)
options: Save_Adaptive_support_files
variables:
  gx = 15.65mm  # total device width
  gy = 13mm  # total device length
  hsub = 0.787mm  # substrate thickness
  cx = 7.9mm  # outer ring side width
  cy = 7.9mm  # outer ring side length
  cd = 0.75mm  # outer ring trace width
  t1 = 0.32mm  # element trace width
  gap = 0.18mm  # element trace gap
  pl = 1.4mm  # aperture separator length
  pw = 0.6mm  # aperture separator width
  vd = 0.3mm  # via diameter
  vs = 0.58mm  # via period
  fl = 0.3mm  # feed transition length
  fw = 1mm  # feed transition width
  fx = 3.1mm  # SIW taper length
  fy = 2.7mm  # SIW taper width
  lWG = (gx-cx)/2
  wWG = 2*fy+vd
  offset = 0.04mm
  Ty = 2.5mm
  t2 = 0.2mm
geometry:
  Substrate [Rogers RT/duroid 5880 (tm)] = box(corner=(0mm, 0mm, 0mm), size=(gx, gy, hsub))
  coordinate_system TopCS = origin=(0mm, 0mm, 0.787mm) x=(1mm, 0mm, 0mm) y=(0mm, 1mm, 0mm)
  coordinate_system WG1CS = origin=(0mm, gy/2, 0mm) x=(1mm, 0mm, 0mm) y=(0mm, 1mm, 0mm) in TopCS
  WG1 = rectangle(corner=(0mm, -wWG/2, 0mm), x_size=lWG, y_size=wWG) in WG1CS
  coordinate_system CenterCS = origin=(gx/2, 0mm, 0mm) x=(1mm, 0mm, 0mm) y=(0mm, 1mm, 0mm) in WG1CS
  WG2 = WG1.duplicate_mirror(point=(0mm, 0mm, 0mm), normal=(1mm, 0mm, 0mm)) in CenterCS
  Outer_Ring = rectangle(corner=(-cx/2, -cy/2, 0mm), x_size=cx, y_size=cy) in CenterCS
  Aperture = rectangle(corner=(-cx/2+cd, -cy/2+cd, 0mm), x_size=cx-2*cd, y_size=cy-2*cd) in CenterCS
  Outer_Ring.subtract(Aperture)
  Separator = rectangle(corner=(-pw/2, -cy/2+cd, 0mm), x_size=pw, y_size=pl) in CenterCS
  Separator_1 = Separator.duplicate_mirror(point=(0mm, 0mm, 0mm), normal=(0mm, 1mm, 0mm)) in CenterCS
  Via = cylinder(axis=Z, base_centre=(0mm, -cy/2+cd/2, 0mm), radius=vd/2, height=-hsub) in CenterCS
  Via_1..Via_5 = Via.duplicate_along_line(step=(vs, 0mm, 0mm), total=6) in CenterCS
  Via_5_1 = Via_5.duplicate_along_line(step=(sqrt((vs)^2-((vd)/2)^2), -vd/2, 0mm), total=2) in CenterCS
  Via1 = cylinder(axis=Z, base_centre=((cx-cd)/2, -fy, 0mm), radius=vd/2, height=-hsub) in CenterCS
  Via1_1 = Via1.duplicate_along_line(step=(0mm, -vs, 0mm), total=2) in CenterCS
  Via1_2..Via1_7 = Via1.duplicate_along_line(step=(sqrt(vs^2-((fy/2)/6)^2)-offset, (fy/2)/6, 0mm), total=7) in CenterCS
  Via1_7_1, Via1_7_2 = Via1_7.duplicate_along_line(step=(vs, 0mm, 0mm), total=3) in CenterCS
  Via_Center = cylinder(axis=Z, base_centre=((cx-cd)/2+6*(sqrt(vs^2-((fy/2)/6)^2)-offset)-fx, 0, 0mm), radius=vd/2, height=-hsub) in CenterCS
  Via.unite(Via_1..Via_5, Via_5_1, Via1, Via1_1..Via1_7, Via1_7_1, Via1_7_2)
  Via_6 = Via.duplicate_mirror(point=(0mm, 0mm, 0mm), normal=(0mm, 1mm, 0mm)) in CenterCS
  Via.unite(Via_6)
  Via_7 = Via.duplicate_mirror(point=(0mm, 0mm, 0mm), normal=(-1mm, 0mm, 0mm)) in CenterCS
  Via_Center_1 = Via_Center.duplicate_mirror(point=(0mm, 0mm, 0mm), normal=(-1mm, 0mm, 0mm)) in CenterCS
  Via.unite(Via_7, Via_Center, Via_Center_1)
  coordinate_system FeedGroundCS = origin=(-cx/2+cd+fl, -Ty/2, -hsub) x=(1mm, 0mm, 0mm) y=(0mm, 1mm, 0mm) in CenterCS
  Feed_Taper = polyline(z=hsub, xy: (-fl, -fw/2) (0, -t1/2) (0, t1/2) (-fl, fw/2) (-fl, -fw/2), closed, covered) in FeedGroundCS
  Feed_Taper_1 = Feed_Taper.duplicate_along_line(step=(0mm, Ty, 0mm), total=2) in FeedGroundCS
  Feed_Taper_2 = Feed_Taper.duplicate_mirror(point=(0mm, 0mm, 0mm), normal=(1mm, 0mm, 0mm)) in CenterCS
  Feed_Taper_1_1 = Feed_Taper_1.duplicate_mirror(point=(0mm, 0mm, 0mm), normal=(1mm, 0mm, 0mm)) in CenterCS
  Outer_Ring.unite(Separator, Separator_1, Feed_Taper, Feed_Taper_1, Feed_Taper_1_1, Feed_Taper_2)
  Via_8 = Via.copy()
  Outer_Ring.subtract(Via_8)
  Via_9 = Via.copy()
  Substrate.subtract(Via_9)
  Via_10 = Via.copy()
  WG1.subtract(Via_10)
  WG2.subtract(Via)
  Region [vacuum] = region(+X=0 percentage offset, -X=0 percentage offset, +Y=0mm absolute offset, -Y=0mm absolute offset, +Z=2mm absolute offset, -Z=1mm absolute offset) in CenterCS
  plane CutPlane = base (0mm, 0mm, -hsub/2) normal (0mm, 0mm, 1mm) in CenterCS
boundaries and excitations:
  Copper: Finite Conductivity Faces=Substrate.face(at (11.1175, 6.5, 0.3935), at (0.272524, 5.15, 0.3935), at (1.43252, 5.15, 0.3935), at (2.42168, 4.7, 0.3935), at (3.41084, 4.25, 0.3935), at (4.4, 3.22, 0.3935), at (4.51473, 2.775, 0.3935), at (5.655, 2.925, 0.3935), at (6.815, 2.925, 0.3935), at (7.675, 2.925, 0.3935), at (7.395, 2.925, 0.3935), at (6.235, 2.925, 0.3935)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) WG2.face Outer_Ring.face(at (7.825, 6.5, 0.787)) WG1.face(at (1.9375, 6.5, 0.787)) UseMaterial Material=copper IsInternal
  Rad1: Radiation Faces=Region.face(all 6)
  1: Wave Port Faces=Substrate.face(at (0, 6.5, 0.3935)) WavePortType=Modal NumModes=1 Modes{Mode1{IntLine{(0, 6.5, 0) -> (0, 6.5, 0.787)} CharImp=Zpi}}
  2: Wave Port Faces=Substrate.face(at (15.65, 6.5, 0.3935)) WavePortType=Modal NumModes=1 Modes{Mode1{IntLine{(15.65, 6.5, 0) -> (15.65, 6.5, 0.787)} CharImp=Zpi}}
setups:
  Setup1: HfssDriven Frequency=60GHz MaxDeltaS=0.02 MaximumPasses=6 MinimumPasses=1 MinimumConvergedPasses=1 PercentRefinement=30 BasisOrder=1 PortAccuracy=2 DrivenSolverType="Direct Solver"
    sweep Sweep: 56GHz to 67GHz step 0.1GHz; Type=Interpolating InterpTolerance=0.5 InterpMaxSolns=250 InterpUsePortImped=false PassivityErrorTolerance=0.0001
source amplitudes:
  1:1: 1W 0deg
  2:1: 1W 180deg
radiation setups:
  3D: Infinite Sphere Theta=0deg..180deg step 2deg Phi=-180deg..180deg step 2deg
  Elevation: Infinite Sphere Theta=-180deg..180deg step 2deg Phi=0deg..90deg step 90deg
field plots:
  Mag_E1, Mag_E2: E Field over a plane on Setup1 : LastAdaptive at Freq=60GHz Phase=0deg

design 5G Aperture Element (HFSS, HFSS Hybrid Modal Network, model units mm)
options: Save_Adaptive_support_files
variables:
  Tx = 2.9mm
  Ty = 2.5mm
  hsub = 0.787mm
  ax = 1.8mm
  tw1 = 0.32mm
  tw2 = 0.32mm
  ay = 1.7mm
  tw3 = 0.32mm
  tw4 = 0.32mm
  gap = 0.18mm
  tw5 = 0.32mm
  tw6 = 0.32mm
  tw7 = 0.32mm
  tw8 = 0.32mm
geometry:
  Substrate [Rogers RT/duroid 5880 (tm)] = box(corner=(0mm, 0mm, 0mm), size=(Tx, Ty, hsub))
  coordinate_system FeedGroundCS = origin=(0mm, Ty/2, 0mm) x=(1mm, 0mm, 0mm) y=(0mm, 1mm, 0mm)
  coordinate_system FeedCS = origin=(0mm, 0mm, hsub) x=(1mm, 0mm, 0mm) y=(0mm, 1mm, 0mm) in FeedGroundCS
  Trace1 = rectangle(corner=(0mm, -tw1/2, 0mm), x_size=(Tx-ax)/2, y_size=tw1) in FeedCS
  Trace2 = rectangle(corner=((Tx-ax)/2, tw1/2, 0), x_size=tw2, y_size=-(ay+tw1)/2) in FeedCS
  Trace3 = rectangle(corner=((Tx-ax)/2+tw2, -ay/2, 0), x_size=ax-tw2, y_size=tw3) in FeedCS
  Trace4 = rectangle(corner=((Tx-ax)/2+tw2+ax-tw2-tw4, -ay/2+tw3, 0), x_size=tw4, y_size=ay/2-tw3-gap-tw5/2) in FeedCS
  coordinate_system CenterCS = origin=(Tx/2, 0mm, 0mm) x=(1mm, 0mm, 0mm) y=(0mm, 1mm, 0mm) in FeedCS
  Trace5 = rectangle(corner=(Tx, -tw5/2, 0mm), x_size=-(Tx-ax)/2, y_size=tw5) in FeedCS
  Trace6 = rectangle(corner=(Tx-(Tx-ax)/2, -tw5/2, 0mm), x_size=-tw6, y_size=(ay+tw5)/2) in FeedCS
  Trace7 = rectangle(corner=((Tx+ax)/2-tw6, (ay)/2, 0mm), x_size=-ax+tw6, y_size=-tw7) in FeedCS
  Trace8 = rectangle(corner=((Tx-ax)/2, ay/2-tw7, 0), x_size=tw8, y_size=-(ay/2-tw7-tw1/2-gap)) in FeedCS
  Trace1.unite(Trace2..Trace8)
boundaries and excitations:
  Copper: Finite Conductivity Objects=Trace1 UseMaterial Material=copper IsInternal

design SIW Feed Structure + 3Dcomp (HFSS, HFSS Hybrid Modal Network, model units mm)
options: Save_Adaptive_support_files
variables:
  gx = 15.65mm  # total device width
  gy = 13mm  # total device length
  hsub = 0.787mm  # substrate thickness
  cx = 7.9mm  # outer ring side width
  cy = 7.9mm  # outer ring side length
  cd = 0.75mm  # outer ring trace width
  t1 = 0.32mm  # element trace width
  gap = 0.18mm  # element trace gap
  pl = 1.4mm  # aperture separator length
  pw = 0.6mm  # aperture separator width
  vd = 0.3mm  # via diameter
  vs = 0.58mm  # via period
  fl = 0.3mm  # feed transition length
  fw = 1mm  # feed transition width
  fx = 3.1mm  # SIW taper length
  fy = 2.7mm  # SIW taper width
  lWG = (gx-cx)/2
  wWG = 2*fy+vd
  offset = 0.04mm
  Ty = 2.5mm
  t2 = 0.2mm
geometry:
  Substrate [Rogers RT/duroid 5880 (tm)] = box(corner=(0mm, 0mm, 0mm), size=(gx, gy, hsub))
  coordinate_system TopCS = origin=(0mm, 0mm, 0.787mm) x=(1mm, 0mm, 0mm) y=(0mm, 1mm, 0mm)
  coordinate_system WG1CS = origin=(0mm, gy/2, 0mm) x=(1mm, 0mm, 0mm) y=(0mm, 1mm, 0mm) in TopCS
  WG1 = rectangle(corner=(0mm, -wWG/2, 0mm), x_size=lWG, y_size=wWG) in WG1CS
  coordinate_system CenterCS = origin=(gx/2, 0mm, 0mm) x=(1mm, 0mm, 0mm) y=(0mm, 1mm, 0mm) in WG1CS
  WG2 = WG1.duplicate_mirror(point=(0mm, 0mm, 0mm), normal=(1mm, 0mm, 0mm)) in CenterCS
  Outer_Ring = rectangle(corner=(-cx/2, -cy/2, 0mm), x_size=cx, y_size=cy) in CenterCS
  Aperture = rectangle(corner=(-cx/2+cd, -cy/2+cd, 0mm), x_size=cx-2*cd, y_size=cy-2*cd) in CenterCS
  Outer_Ring.subtract(Aperture)
  Separator = rectangle(corner=(-pw/2, -cy/2+cd, 0mm), x_size=pw, y_size=pl) in CenterCS
  Separator_1 = Separator.duplicate_mirror(point=(0mm, 0mm, 0mm), normal=(0mm, 1mm, 0mm)) in CenterCS
  Via = cylinder(axis=Z, base_centre=(0mm, -cy/2+cd/2, 0mm), radius=vd/2, height=-hsub) in CenterCS
  Via_1..Via_5 = Via.duplicate_along_line(step=(vs, 0mm, 0mm), total=6) in CenterCS
  Via_5_1 = Via_5.duplicate_along_line(step=(sqrt((vs)^2-((vd)/2)^2), -vd/2, 0mm), total=2) in CenterCS
  Via1 = cylinder(axis=Z, base_centre=((cx-cd)/2, -fy, 0mm), radius=vd/2, height=-hsub) in CenterCS
  Via1_1 = Via1.duplicate_along_line(step=(0mm, -vs, 0mm), total=2) in CenterCS
  Via1_2..Via1_7 = Via1.duplicate_along_line(step=(sqrt(vs^2-((fy/2)/6)^2)-offset, (fy/2)/6, 0mm), total=7) in CenterCS
  Via1_7_1, Via1_7_2 = Via1_7.duplicate_along_line(step=(vs, 0mm, 0mm), total=3) in CenterCS
  Via_Center = cylinder(axis=Z, base_centre=((cx-cd)/2+6*(sqrt(vs^2-((fy/2)/6)^2)-offset)-fx, 0, 0mm), radius=vd/2, height=-hsub) in CenterCS
  Via.unite(Via_1..Via_5, Via_5_1, Via1, Via1_1..Via1_7, Via1_7_1, Via1_7_2)
  Via_6 = Via.duplicate_mirror(point=(0mm, 0mm, 0mm), normal=(0mm, 1mm, 0mm)) in CenterCS
  Via.unite(Via_6)
  Via_7 = Via.duplicate_mirror(point=(0mm, 0mm, 0mm), normal=(-1mm, 0mm, 0mm)) in CenterCS
  Via_Center_1 = Via_Center.duplicate_mirror(point=(0mm, 0mm, 0mm), normal=(-1mm, 0mm, 0mm)) in CenterCS
  Via.unite(Via_7, Via_Center, Via_Center_1)
  coordinate_system FeedGroundCS = origin=(-cx/2+cd+fl, -Ty/2, -hsub) x=(1mm, 0mm, 0mm) y=(0mm, 1mm, 0mm) in CenterCS
  Feed_Taper = polyline(z=hsub, xy: (-fl, -fw/2) (0, -t1/2) (0, t1/2) (-fl, fw/2) (-fl, -fw/2), closed, covered) in FeedGroundCS
  Feed_Taper_1 = Feed_Taper.duplicate_along_line(step=(0mm, Ty, 0mm), total=2) in FeedGroundCS
  Feed_Taper_2 = Feed_Taper.duplicate_mirror(point=(0mm, 0mm, 0mm), normal=(1mm, 0mm, 0mm)) in CenterCS
  Feed_Taper_1_1 = Feed_Taper_1.duplicate_mirror(point=(0mm, 0mm, 0mm), normal=(1mm, 0mm, 0mm)) in CenterCS
  Outer_Ring.unite(Separator, Separator_1, Feed_Taper, Feed_Taper_1, Feed_Taper_1_1, Feed_Taper_2)
  Via_8 = Via.copy()
  Outer_Ring.subtract(Via_8)
  Via_9 = Via.copy()
  Substrate.subtract(Via_9)
  Via_10 = Via.copy()
  WG1.subtract(Via_10)
  WG2.subtract(Via)
  Region [vacuum] = region(+X=0 percentage offset, -X=0 percentage offset, +Y=0mm absolute offset, -Y=0mm absolute offset, +Z=2mm absolute offset, -Z=1mm absolute offset) in CenterCS
  plane CutPlane = base (0mm, 0mm, -hsub/2) normal (0mm, 0mm, 1mm) in CenterCS
  5G_CPAA_Element1 = component(5G_CPAA_Element, 3D_Component_File_Path=<psnllib>/3DComponents/5G_CPAA_Element.a3dcomp, Ty=2.5mm, Tx=2.9mm, hsub=0.787mm, gap=0.18mm, ax=1.8mm, tw1=0.32mm, tw2=0.32mm, ay=1.7mm, tw3=0.32mm, tw4=0.32mm, tw5=t2, tw6=0.32mm, tw7=0.32mm, tw8=0.32mm)
  Substrate_1 [Rogers RT/duroid 5880 (tm)] = part_of(5G_CPAA_Element1) in FeedGroundCS
  Trace1 [vacuum] = part_of(5G_CPAA_Element1) in FeedGroundCS
  5G_CPAA_Element1.duplicate_along_line(XComponent=0mm YComponent=Ty ZComponent=0mm NumClones=2) in FeedGroundCS
  5G_CPAA_Element2 = component(5G_CPAA_Element)
  coordinate_system FeedGroundCS2 = cached_coordinate_system()
  5G_CPAA_Element2.from_dup_along_line(SourceID=3752 WhichClone=0)
  5G_CPAA_Element1.duplicate_around_axis(WhichAxis=Z AngleStr=180deg NumClones=2) in CenterCS
  5G_CPAA_Element3 = component(5G_CPAA_Element)
  coordinate_system FeedGroundCS3 = cached_coordinate_system()
  5G_CPAA_Element3.from_dup_around_axis(SourceID=3752 WhichClone=0)
  5G_CPAA_Element2.duplicate_around_axis(WhichAxis=Z AngleStr=180deg NumClones=2) in CenterCS
  5G_CPAA_Element4 = component(5G_CPAA_Element)
  coordinate_system FeedGroundCS4 = cached_coordinate_system()
  5G_CPAA_Element4.from_dup_around_axis(SourceID=3830 WhichClone=0)
boundaries and excitations:
  5G_CPAA_Element1_Copper: Finite Conductivity Objects=Trace1 UseMaterial Material=5G_CPAA_Element1:copper IsInternal
  5G_CPAA_Element2_Copper: Finite Conductivity Objects=Trace2 UseMaterial Material=5G_CPAA_Element1:copper IsInternal
  5G_CPAA_Element3_Copper: Finite Conductivity Objects=Trace3 UseMaterial Material=5G_CPAA_Element1:copper IsInternal
  5G_CPAA_Element4_Copper: Finite Conductivity Objects=Trace4 UseMaterial Material=5G_CPAA_Element1:copper IsInternal
  Copper: Finite Conductivity Faces=Substrate.face(at (11.1175, 6.5, 0.3935), at (0.272524, 5.15, 0.3935), at (1.43252, 5.15, 0.3935), at (2.42168, 4.7, 0.3935), at (3.41084, 4.25, 0.3935), at (4.4, 3.22, 0.3935), at (4.51473, 2.775, 0.3935), at (5.655, 2.925, 0.3935), at (6.815, 2.925, 0.3935), at (7.675, 2.925, 0.3935), at (7.395, 2.925, 0.3935), at (6.235, 2.925, 0.3935)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) WG2.face Outer_Ring.face(at (7.825, 6.5, 0.787)) WG1.face(at (1.9375, 6.5, 0.787)) UseMaterial Material=copper IsInternal
  Rad1: Radiation Faces=Region.face(all 6)
  1: Wave Port Faces=Substrate.face(at (0, 6.5, 0.3935)) WavePortType=Modal NumModes=1 Modes{Mode1{IntLine{(0, 6.5, 0) -> (0, 6.5, 0.787)} CharImp=Zpi}}
  2: Wave Port Faces=Substrate.face(at (15.65, 6.5, 0.3935)) WavePortType=Modal NumModes=1 Modes{Mode1{IntLine{(15.65, 6.5, 0) -> (15.65, 6.5, 0.787)} CharImp=Zpi}}
setups:
  Setup1: HfssDriven Frequency=60GHz MaxDeltaS=0.02 MaximumPasses=6 MinimumPasses=1 MinimumConvergedPasses=1 PercentRefinement=30 BasisOrder=1 PortAccuracy=2 DrivenSolverType="Direct Solver"
    sweep Sweep: 56GHz to 67GHz step 0.1GHz; Type=Interpolating InterpTolerance=0.5 InterpMaxSolns=250 InterpUsePortImped=false PassivityErrorTolerance=0.0001
source amplitudes:
  1:1: 1W 0deg
  2:1: 1W 180deg
radiation setups:
  3D: Infinite Sphere Theta=0deg..180deg step 2deg Phi=-180deg..180deg step 2deg
  Elevation: Infinite Sphere Theta=-180deg..180deg step 2deg Phi=0deg..90deg step 90deg
field plots:
  Mag_E1, Mag_E2: E Field over a plane on Setup1 : LastAdaptive at Freq=60GHz Phase=0deg
